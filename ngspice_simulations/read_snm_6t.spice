* Phase 2: SKY130 6T SRAM Core - Read Static Noise Margin (RSNM)
* Target: SkyWater 130nm PDK (1.8V, TT Corner)

*** 1. FOUNDRY PDK INCLUSION & SEARCH PATH ***
.options search="/mnt/c/Users/yashw/SRAM_SKY130/OPENRAM/sky130A/models"
.lib "/mnt/c/Users/yashw/SRAM_SKY130/OPENRAM/sky130A/models/sky130.lib.spice" tt

*** 2. THE 6T SRAM CELL DEFINITION (DRC COMPLIANT) ***
* We expose the internal gate nodes separately to break the feedback loop for the DC sweep
.subckt sram_6t_cell WL BL BLB VDD VSS Q QB Q_gate QB_gate
* Pull-Down NMOS (Sized at W=0.84um for a robust Cell Ratio)
XNM1 QB Q_gate VSS VSS sky130_fd_pr__nfet_01v8 w=0.84 l=0.15
XNM2 Q  QB_gate VSS VSS sky130_fd_pr__nfet_01v8 w=0.84 l=0.15

* Pull-Up PMOS (Sized at Sky130 manufacturing minimum width W=0.42um)
XPM1 QB Q_gate VDD VDD sky130_fd_pr__pfet_01v8 w=0.42 l=0.15
XPM2 Q  QB_gate VDD VDD sky130_fd_pr__pfet_01v8 w=0.42 l=0.15

* Pass-Gate NMOS (Access transistors sized at W=0.42um; CR = 0.84/0.42 = 2.0)
XMA1 BLB WL QB VSS sky130_fd_pr__nfet_01v8 w=0.42 l=0.15
XMA2 BL  WL Q  VSS sky130_fd_pr__nfet_01v8 w=0.42 l=0.15
.ends

*** 3. TESTBENCH BIASING (READ CONDITION) ***
Vdd  VDD  0 DC 1.8
Vss  VSS  0 DC 0

* For a Read operation, Wordline is active (1.8V) and both Bitlines are pre-charged high
Vwl  WL   0 DC 1.8
Vbl  BL   0 DC 1.8
Vblb BLB  0 DC 1.8

* Independent sweep voltage source
Vsrc Vsweep 0 DC 0

*** 4. BREAKING THE LATCH INTERNALLY FOR BUTTERFLY SCATTER ***
* We instantiate two cross-coupled half-cells to map out the voltage transfer curves (VTC)
Xcell1 WL BL BLB VDD VSS Q1 QB1 Vsweep VSS sram_6t_cell
Xcell2 WL BL BLB VDD VSS Q2 QB2 VSS    Vsweep sram_6t_cell

*** 5. SIMULATION DIRECTIVE ***
.dc Vsrc 0 1.8 0.01

*** 6. PLOTTING CONTROL ***
.control
run
set xbrushwidth=2
plot v(qb1) vs v(vsweep) v(vsweep) vs v(q2) title 'Phase 1: 6T SRAM RSNM Butterfly Curve (Real Sky130 PDK)' xl 0 1.8 yl 0 1.8
.endc

.end
